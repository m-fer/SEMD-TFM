* cell AN2D8HPBWP
* pin GND
* pin VDD
.SUBCKT AN2D8HPBWP GND VDD
* device instance $1 r0 *1 0.26,0.47 NMOS
M$1 \$7 \$2 \$3 \$3 NMOS L=0.06U W=0.54U AS=0.0891P AD=0.054P PS=1.41U PD=0.74U
* device instance $2 r0 *1 0.52,0.47 NMOS
M$2 GND \$4 \$7 \$7 NMOS L=0.06U W=0.54U AS=0.054P AD=0.054P PS=0.74U PD=0.74U
* device instance $3 r0 *1 0.78,0.47 NMOS
M$3 \$10 \$4 GND GND NMOS L=0.06U W=0.54U AS=0.054P AD=0.054P PS=0.74U PD=0.74U
* device instance $4 r0 *1 1.04,0.47 NMOS
M$4 \$3 \$2 \$10 \$10 NMOS L=0.06U W=0.54U AS=0.054P AD=0.054P PS=0.74U PD=0.74U
* device instance $5 r0 *1 1.3,0.47 NMOS
M$5 \$15 \$2 \$3 \$3 NMOS L=0.06U W=0.54U AS=0.054P AD=0.054P PS=0.74U PD=0.74U
* device instance $6 r0 *1 1.56,0.47 NMOS
M$6 GND \$4 \$15 \$15 NMOS L=0.06U W=0.54U AS=0.054P AD=0.081P PS=0.74U PD=0.84U
* device instance $7 r0 *1 1.92,0.47 NMOS
M$7 \$5 \$3 GND GND NMOS L=0.06U W=4.32U AS=0.459P AD=0.4644P PS=6.02U PD=6.58U
* device instance $15 r0 *1 0.26,1.43 PMOS
M$15 \$3 \$2 VDD VDD PMOS L=0.06U W=2.22U AS=0.2664P AD=0.222P PS=3.68U PD=2.82U
* device instance $16 r0 *1 0.52,1.43 PMOS
M$16 VDD \$4 \$3 \$3 PMOS L=0.06U W=2.22U AS=0.222P AD=0.259P PS=2.82U PD=2.92U
* device instance $21 r0 *1 1.92,1.43 PMOS
M$21 \$5 \$3 VDD VDD PMOS L=0.06U W=5.92U AS=0.629P AD=0.6364P PS=7.62U PD=8.38U
.ENDS AN2D8HPBWP
