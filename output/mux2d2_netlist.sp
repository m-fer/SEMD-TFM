* cell MUX2D2HPBWP
* pin GND
* pin VDD
.SUBCKT MUX2D2HPBWP GND VDD
* device instance $1 r0 *1 1.06,0.38 NMOS
M$1 \$2 \$5 \$8 \$8 NMOS L=0.06U W=0.36U AS=0.0444P AD=0.0477P PS=0.76U PD=0.74U
* device instance $2 r0 *1 0.26,0.545 NMOS
M$2 GND \$5 \$7 \$7 NMOS L=0.06U W=0.27U AS=0.0432P AD=0.0315P PS=0.86U PD=0.53U
* device instance $3 r0 *1 0.52,0.575 NMOS
M$3 \$1 \$4 GND GND NMOS L=0.06U W=0.33U AS=0.0315P AD=0.033P PS=0.53U PD=0.53U
* device instance $4 r0 *1 0.78,0.575 NMOS
M$4 \$1 \$7 \$8 \$8 NMOS L=0.06U W=0.33U AS=0.0444P AD=0.033P PS=0.76U PD=0.53U
* device instance $5 r0 *1 1.32,0.47 NMOS
M$5 GND \$6 \$2 \$2 NMOS L=0.06U W=0.54U AS=0.0477P AD=0.07155P PS=0.74U
+ PD=0.805U
* device instance $6 r0 *1 1.645,0.47 NMOS
M$6 \$3 \$8 GND GND NMOS L=0.06U W=1.08U AS=0.12555P AD=0.1593P PS=1.545U
+ PD=2.21U
* device instance $8 r0 *1 1.1,1.29 PMOS
M$8 \$2 \$7 \$8 \$8 PMOS L=0.06U W=0.46U AS=0.0586P AD=0.06555P PS=0.94U
+ PD=0.955U
* device instance $9 r0 *1 0.56,1.33 PMOS
M$9 \$1 \$4 VDD VDD PMOS L=0.06U W=0.54U AS=0.0673P AD=0.0714P PS=0.895U
+ PD=0.96U
* device instance $10 r0 *1 0.265,1.535 PMOS
M$10 \$7 \$5 VDD VDD PMOS L=0.06U W=0.37U AS=0.0673P AD=0.06105P PS=0.895U
+ PD=1.07U
* device instance $11 r0 *1 0.84,1.49 PMOS
M$11 \$8 \$5 \$1 \$1 PMOS L=0.06U W=0.62U AS=0.0714P AD=0.0586P PS=0.96U
+ PD=0.94U
* device instance $12 r0 *1 1.375,1.43 PMOS
M$12 VDD \$6 \$2 \$2 PMOS L=0.06U W=0.74U AS=0.06555P AD=0.0888P PS=0.955U
+ PD=0.98U
* device instance $13 r0 *1 1.675,1.43 PMOS
M$13 \$3 \$8 VDD VDD PMOS L=0.06U W=1.48U AS=0.1628P AD=0.1961P PS=1.92U
+ PD=2.75U
.ENDS MUX2D2HPBWP
