* cell AN4D2HPBWP
* pin GND
* pin VDD
.SUBCKT AN4D2HPBWP GND VDD
* device instance $1 r0 *1 0.275,0.47 NMOS
M$1 \$15 \$6 \$1 \$1 NMOS L=0.06U W=0.54U AS=0.0972P AD=0.054P PS=1.44U PD=0.74U
* device instance $2 r0 *1 0.535,0.47 NMOS
M$2 \$16 \$5 \$15 \$15 NMOS L=0.06U W=0.54U AS=0.054P AD=0.054P PS=0.74U
+ PD=0.74U
* device instance $3 r0 *1 0.795,0.47 NMOS
M$3 \$17 \$4 \$16 \$16 NMOS L=0.06U W=0.54U AS=0.054P AD=0.054P PS=0.74U
+ PD=0.74U
* device instance $4 r0 *1 1.055,0.47 NMOS
M$4 GND \$3 \$17 \$17 NMOS L=0.06U W=0.54U AS=0.054P AD=0.06075P PS=0.74U
+ PD=0.765U
* device instance $5 r0 *1 1.34,0.47 NMOS
M$5 \$8 \$1 GND GND NMOS L=0.06U W=1.08U AS=0.11475P AD=0.1647P PS=1.505U
+ PD=2.23U
* device instance $7 r0 *1 0.275,1.43 PMOS
M$7 \$1 \$6 VDD VDD PMOS L=0.06U W=0.74U AS=0.1295P AD=0.074P PS=1.83U PD=0.94U
* device instance $8 r0 *1 0.535,1.43 PMOS
M$8 VDD \$5 \$1 \$1 PMOS L=0.06U W=0.74U AS=0.074P AD=0.074P PS=0.94U PD=0.94U
* device instance $9 r0 *1 0.795,1.43 PMOS
M$9 \$1 \$4 VDD VDD PMOS L=0.06U W=0.74U AS=0.074P AD=0.074P PS=0.94U PD=0.94U
* device instance $10 r0 *1 1.055,1.43 PMOS
M$10 VDD \$3 \$1 \$1 PMOS L=0.06U W=0.74U AS=0.074P AD=0.08325P PS=0.94U
+ PD=0.965U
* device instance $11 r0 *1 1.34,1.43 PMOS
M$11 \$8 \$1 VDD VDD PMOS L=0.06U W=1.48U AS=0.15725P AD=0.2257P PS=1.905U
+ PD=2.83U
.ENDS AN4D2HPBWP
