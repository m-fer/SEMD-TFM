* cell AN3D2HPBWP
* pin VDD
* pin GND
.SUBCKT AN3D2HPBWP VDD GND
* device instance $1 r0 *1 0.285,0.47 NMOS
M$1 \$13 \$4 \$1 \$1 NMOS L=0.06U W=0.54U AS=0.0999P AD=0.0486P PS=1.45U
+ PD=0.72U
* device instance $2 r0 *1 0.525,0.47 NMOS
M$2 \$14 \$3 \$13 \$13 NMOS L=0.06U W=0.54U AS=0.0486P AD=0.0486P PS=0.72U
+ PD=0.72U
* device instance $3 r0 *1 0.765,0.47 NMOS
M$3 GND \$2 \$14 \$14 NMOS L=0.06U W=0.54U AS=0.0486P AD=0.0675P PS=0.72U
+ PD=0.79U
* device instance $4 r0 *1 1.075,0.47 NMOS
M$4 \$5 \$1 GND GND NMOS L=0.06U W=1.08U AS=0.1215P AD=0.1431P PS=1.53U PD=2.15U
* device instance $6 r0 *1 0.285,1.43 PMOS
M$6 VDD \$4 \$1 \$1 PMOS L=0.06U W=0.74U AS=0.1369P AD=0.074P PS=1.85U PD=0.94U
* device instance $7 r0 *1 0.545,1.43 PMOS
M$7 \$1 \$3 VDD VDD PMOS L=0.06U W=0.74U AS=0.074P AD=0.074P PS=0.94U PD=0.94U
* device instance $8 r0 *1 0.805,1.43 PMOS
M$8 VDD \$2 \$1 \$1 PMOS L=0.06U W=0.74U AS=0.074P AD=0.0777P PS=0.94U PD=0.95U
* device instance $9 r0 *1 1.075,1.43 PMOS
M$9 \$5 \$1 VDD VDD PMOS L=0.06U W=1.48U AS=0.1517P AD=0.1961P PS=1.89U PD=2.75U
.ENDS AN3D2HPBWP
