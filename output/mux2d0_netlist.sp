* cell MUX2D0HPBWP
* pin GND
* pin VDD
.SUBCKT MUX2D0HPBWP GND VDD
* device instance $1 r0 *1 1.035,0.385 NMOS
M$1 \$15 \$3 \$6 \$6 NMOS L=0.06U W=0.27U AS=0.036P AD=0.024975P PS=0.66U
+ PD=0.455U
* device instance $2 r0 *1 1.28,0.385 NMOS
M$2 GND \$4 \$15 \$15 NMOS L=0.06U W=0.27U AS=0.024975P AD=0.027P PS=0.455U
+ PD=0.47U
* device instance $3 r0 *1 1.54,0.385 NMOS
M$3 \$1 \$6 GND GND NMOS L=0.06U W=0.27U AS=0.027P AD=0.0432P PS=0.47U PD=0.86U
* device instance $4 r0 *1 0.265,0.565 NMOS
M$4 GND \$3 \$5 \$5 NMOS L=0.06U W=0.27U AS=0.04455P AD=0.027P PS=0.87U PD=0.47U
* device instance $5 r0 *1 0.525,0.565 NMOS
M$5 \$16 \$2 GND GND NMOS L=0.06U W=0.27U AS=0.027P AD=0.0243P PS=0.47U PD=0.45U
* device instance $6 r0 *1 0.765,0.565 NMOS
M$6 \$16 \$5 \$6 \$6 NMOS L=0.06U W=0.27U AS=0.036P AD=0.0243P PS=0.66U PD=0.45U
* device instance $7 r0 *1 0.535,1.335 PMOS
M$7 \$23 \$2 VDD VDD PMOS L=0.06U W=0.37U AS=0.04985P AD=0.0333P PS=0.78U
+ PD=0.55U
* device instance $8 r0 *1 0.775,1.335 PMOS
M$8 \$6 \$3 \$23 \$23 PMOS L=0.06U W=0.37U AS=0.0333P AD=0.037P PS=0.55U
+ PD=0.57U
* device instance $9 r0 *1 1.035,1.335 PMOS
M$9 \$24 \$5 \$6 \$6 PMOS L=0.06U W=0.37U AS=0.037P AD=0.042725P PS=0.57U
+ PD=0.755U
* device instance $10 r0 *1 0.265,1.535 PMOS
M$10 \$5 \$3 VDD VDD PMOS L=0.06U W=0.37U AS=0.04985P AD=0.06105P PS=0.78U
+ PD=1.07U
* device instance $11 r0 *1 1.28,1.535 PMOS
M$11 VDD \$4 \$24 \$24 PMOS L=0.06U W=0.37U AS=0.042725P AD=0.037P PS=0.755U
+ PD=0.57U
* device instance $12 r0 *1 1.54,1.535 PMOS
M$12 \$1 \$6 VDD VDD PMOS L=0.06U W=0.37U AS=0.037P AD=0.0592P PS=0.57U PD=1.06U
.ENDS MUX2D0HPBWP
