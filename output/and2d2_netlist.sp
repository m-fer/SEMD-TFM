* cell AN2D2HPBWP
* pin GND
* pin VDD
.SUBCKT AN2D2HPBWP GND VDD
* device instance $1 r0 *1 0.285,0.47 NMOS
M$1 \$11 \$4 \$1 \$1 NMOS L=0.06U W=0.54U AS=0.0999P AD=0.054P PS=1.45U PD=0.74U
* device instance $2 r0 *1 0.545,0.47 NMOS
M$2 GND \$3 \$11 \$11 NMOS L=0.06U W=0.54U AS=0.054P AD=0.0675P PS=0.74U
+ PD=0.79U
* device instance $3 r0 *1 0.855,0.47 NMOS
M$3 \$5 \$1 GND GND NMOS L=0.06U W=1.08U AS=0.1215P AD=0.1539P PS=1.53U PD=2.19U
* device instance $5 r0 *1 0.32,1.43 PMOS
M$5 \$1 \$4 VDD VDD PMOS L=0.06U W=0.74U AS=0.1628P AD=0.0777P PS=1.92U PD=0.95U
* device instance $6 r0 *1 0.59,1.43 PMOS
M$6 VDD \$3 \$1 \$1 PMOS L=0.06U W=0.74U AS=0.0777P AD=0.074P PS=0.95U PD=0.94U
* device instance $7 r0 *1 0.85,1.43 PMOS
M$7 \$5 \$1 VDD VDD PMOS L=0.06U W=1.48U AS=0.14985P AD=0.21275P PS=1.885U
+ PD=2.795U
.ENDS AN2D2HPBWP
