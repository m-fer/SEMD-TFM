* cell AN2D4HPBWP
* pin VDD
* pin GND
.SUBCKT AN2D4HPBWP VDD GND
* device instance $1 r0 *1 0.265,0.47 NMOS
M$1 \$15 \$6 GND GND NMOS L=0.06U W=0.54U AS=0.0891P AD=0.054P PS=1.41U PD=0.74U
* device instance $2 r0 *1 0.525,0.47 NMOS
M$2 \$5 \$1 \$15 \$15 NMOS L=0.06U W=0.54U AS=0.054P AD=0.054P PS=0.74U PD=0.74U
* device instance $3 r0 *1 0.785,0.47 NMOS
M$3 \$16 \$1 \$5 \$5 NMOS L=0.06U W=0.54U AS=0.054P AD=0.054P PS=0.74U PD=0.74U
* device instance $4 r0 *1 1.045,0.47 NMOS
M$4 GND \$6 \$16 \$16 NMOS L=0.06U W=0.54U AS=0.054P AD=0.054P PS=0.74U PD=0.74U
* device instance $5 r0 *1 1.305,0.47 NMOS
M$5 \$2 \$5 GND GND NMOS L=0.06U W=2.16U AS=0.23085P AD=0.26325P PS=3.015U
+ PD=3.675U
* device instance $9 r0 *1 0.265,1.43 PMOS
M$9 \$5 \$6 VDD VDD PMOS L=0.06U W=1.48U AS=0.1961P AD=0.148P PS=2.75U PD=1.88U
* device instance $10 r0 *1 0.525,1.43 PMOS
M$10 VDD \$1 \$5 \$5 PMOS L=0.06U W=1.48U AS=0.148P AD=0.148P PS=1.88U PD=1.88U
* device instance $13 r0 *1 1.305,1.43 PMOS
M$13 \$2 \$5 VDD VDD PMOS L=0.06U W=2.96U AS=0.31635P AD=0.36075P PS=3.815U
+ PD=4.675U
.ENDS AN2D4HPBWP
