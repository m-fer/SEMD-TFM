* cell TOP
* pin VDD
* pin GND
.SUBCKT TOP VDD GND
* device instance $1 r0 *1 222.383,-292.802 NMOS
M$1 \$5 \$4 GND GND NMOS L=28.662604476U W=128.551U AS=13048.948417P
+ AD=10995.612328P PS=383.2215U PD=428.445U
* device instance $2 r0 *1 50.448,-291.664 NMOS
M$2 \$10 \$1 GND GND NMOS L=30.1533112058U W=127.3675U AS=13048.948417P
+ AD=5936.3533025P PS=383.2215U PD=220.728U
* device instance $3 r0 *1 -72.853,-291.81 NMOS
M$3 \$10 \$2 \$4 \$4 NMOS L=31.2441437951U W=128.391U AS=11213.178178P
+ AD=5936.3533025P PS=431.782U PD=220.728U
* device instance $4 r0 *1 -53.748,156.159 PMOS
M$4 \$4 \$2 VDD VDD PMOS L=27.5468466988U W=179.692U AS=17681.953782P
+ AD=8969.3661105P PS=556.186U PD=279.524U
* device instance $5 r0 *1 75.054,156.159 PMOS
M$5 VDD \$1 \$4 \$4 PMOS L=31.2768259411U W=179.692U AS=8969.3661105P
+ AD=10410.577776P PS=279.524U PD=295.563U
* device instance $6 r0 *1 221.939,156.159 PMOS
M$6 \$5 \$4 VDD VDD PMOS L=30.305U W=179.691U AS=10410.577776P AD=15183.350427P
+ PS=295.563U PD=528.376U
.ENDS TOP
