* cell BUFFD16HPBWP
* pin GND
* pin VDD
.SUBCKT BUFFD16HPBWP GND VDD
* device instance $1 r0 *1 0.275,0.47 NMOS
M$1 GND \$2 \$3 \$3 NMOS L=0.06U W=2.7U AS=0.3105P AD=0.27P PS=4.39U PD=3.7U
* device instance $6 r0 *1 1.575,0.47 NMOS
M$6 \$4 \$3 GND GND NMOS L=0.06U W=8.64U AS=0.864P AD=0.9207P PS=11.84U
+ PD=12.59U
* device instance $22 r0 *1 0.275,1.43 PMOS
M$22 VDD \$2 \$3 \$3 PMOS L=0.06U W=3.7U AS=0.4255P AD=0.37P PS=5.59U PD=4.7U
* device instance $27 r0 *1 1.575,1.43 PMOS
M$27 \$4 \$3 VDD VDD PMOS L=0.06U W=11.84U AS=1.184P AD=1.2617P PS=15.04U
+ PD=15.99U
.ENDS BUFFD16HPBWP
