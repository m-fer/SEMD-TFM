* cell TOP
* pin VDD
* pin GND
.SUBCKT TOP VDD GND
* device instance $1 r0 *1 377.452,-293.824 NMOS
M$1 \$5 \$4 GND GND NMOS L=39.848U W=129.637U AS=14396.10209P AD=7772.619392P
+ PS=481.533U PD=249.514U
* device instance $2 r0 *1 222.383,-292.802 NMOS
M$2 \$5 \$4 GND GND NMOS L=28.662604476U W=128.551U AS=13048.948417P
+ AD=7772.619392P PS=383.2215U PD=249.514U
* device instance $3 r0 *1 50.448,-291.664 NMOS
M$3 \$11 \$1 GND GND NMOS L=30.1533112058U W=127.3675U AS=13048.948417P
+ AD=5936.3533025P PS=383.2215U PD=220.728U
* device instance $4 r0 *1 -72.853,-291.81 NMOS
M$4 \$11 \$2 \$4 \$4 NMOS L=31.2441437951U W=128.391U AS=11213.178178P
+ AD=5936.3533025P PS=431.782U PD=220.728U
* device instance $5 r0 *1 -53.748,156.159 PMOS
M$5 \$4 \$2 VDD VDD PMOS L=27.5468466988U W=179.692U AS=17681.953782P
+ AD=8969.3661105P PS=556.186U PD=279.524U
* device instance $6 r0 *1 75.054,156.159 PMOS
M$6 VDD \$1 \$4 \$4 PMOS L=31.2768259411U W=179.692U AS=8969.3661105P
+ AD=10410.577776P PS=279.524U PD=295.563U
* device instance $7 r0 *1 221.939,156.159 PMOS
M$7 \$5 \$4 VDD VDD PMOS L=30.305U W=179.691U AS=10410.577776P AD=10820.632638P
+ PS=295.563U PD=300.127U
* device instance $8 r0 *1 377.452,156.159 PMOS
M$8 VDD \$4 \$5 \$5 PMOS L=39.848U W=179.691U AS=10820.632638P AD=19889.99679P
+ PS=300.127U PD=580.762U
.ENDS TOP
