* cell MUX2D4HPBWP
* pin GND
* pin VDD
.SUBCKT MUX2D4HPBWP GND VDD
* device instance $1 r0 *1 1.04,0.38 NMOS
M$1 \$6 \$2 \$5 \$5 NMOS L=0.06U W=0.36U AS=0.0477P AD=0.0576P PS=0.74U PD=1.04U
* device instance $2 r0 *1 0.26,0.47 NMOS
M$2 GND \$20 \$3 \$3 NMOS L=0.06U W=1.08U AS=0.1404P AD=0.108P PS=2.14U PD=1.48U
* device instance $4 r0 *1 0.78,0.47 NMOS
M$4 \$5 \$4 \$3 \$3 NMOS L=0.06U W=0.54U AS=0.054P AD=0.0477P PS=0.74U PD=0.74U
* device instance $5 r0 *1 1.55,0.47 NMOS
M$5 GND \$2 \$4 \$4 NMOS L=0.06U W=0.54U AS=0.0864P AD=0.0621P PS=1.4U PD=0.77U
* device instance $6 r0 *1 1.84,0.47 NMOS
M$6 \$6 \$7 GND GND NMOS L=0.06U W=1.08U AS=0.1161P AD=0.108P PS=1.51U PD=1.48U
* device instance $8 r0 *1 2.36,0.47 NMOS
M$8 \$8 \$5 GND GND NMOS L=0.06U W=2.16U AS=0.216P AD=0.2484P PS=2.96U PD=3.62U
* device instance $12 r0 *1 1.55,1.317 PMOS
M$12 VDD \$2 \$4 \$4 PMOS L=0.06U W=0.515U AS=0.0824P AD=0.0882P PS=1.35U
+ PD=1.135U
* device instance $13 r0 *1 1.84,1.42 PMOS
M$13 \$6 \$7 VDD VDD PMOS L=0.06U W=1.44U AS=0.1602P AD=0.1455P PS=2.055U
+ PD=1.86U
* device instance $15 r0 *1 2.36,1.43 PMOS
M$15 \$8 \$5 VDD VDD PMOS L=0.06U W=2.96U AS=0.2955P AD=0.3404P PS=3.76U
+ PD=4.62U
* device instance $19 r0 *1 1.04,1.33 PMOS
M$19 \$6 \$4 \$5 \$5 PMOS L=0.06U W=0.54U AS=0.0641P AD=0.0864P PS=0.94U PD=1.4U
* device instance $20 r0 *1 0.26,1.43 PMOS
M$20 VDD \$20 \$3 \$3 PMOS L=0.06U W=1.48U AS=0.1924P AD=0.1447P PS=2.74U
+ PD=1.88U
* device instance $22 r0 *1 0.78,1.49 PMOS
M$22 \$5 \$2 \$3 \$3 PMOS L=0.06U W=0.62U AS=0.0707P AD=0.0641P PS=0.94U
+ PD=0.94U
.ENDS MUX2D4HPBWP
