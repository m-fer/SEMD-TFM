* cell BUFFD12HPBWP
* pin GND
* pin VDD
.SUBCKT BUFFD12HPBWP GND VDD
* device instance $1 r0 *1 0.26,0.47 NMOS
M$1 \$4 \$2 GND GND NMOS L=0.06U W=2.16U AS=0.2484P AD=0.23895P PS=3.62U
+ PD=3.045U
* device instance $5 r0 *1 1.385,0.47 NMOS
M$5 \$3 \$4 GND GND NMOS L=0.06U W=6.48U AS=0.67095P AD=0.7047P PS=8.965U
+ PD=9.63U
* device instance $17 r0 *1 0.26,1.43 PMOS
M$17 \$4 \$2 VDD VDD PMOS L=0.06U W=2.96U AS=0.3404P AD=0.32745P PS=4.62U
+ PD=3.845U
* device instance $21 r0 *1 1.385,1.43 PMOS
M$21 \$3 \$4 VDD VDD PMOS L=0.06U W=8.88U AS=0.91945P AD=0.9657P PS=11.365U
+ PD=12.23U
.ENDS BUFFD12HPBWP
