* cell AN3D4HPBWP
* pin VDD
* pin GND
.SUBCKT AN3D4HPBWP VDD GND
* device instance $1 r0 *1 0.26,0.47 NMOS
M$1 \$18 \$7 GND GND NMOS L=0.06U W=0.54U AS=0.0864P AD=0.054P PS=1.4U PD=0.74U
* device instance $2 r0 *1 0.52,0.47 NMOS
M$2 \$19 \$2 \$18 \$18 NMOS L=0.06U W=0.54U AS=0.054P AD=0.054P PS=0.74U
+ PD=0.74U
* device instance $3 r0 *1 0.78,0.47 NMOS
M$3 \$1 \$3 \$19 \$19 NMOS L=0.06U W=0.54U AS=0.054P AD=0.054P PS=0.74U PD=0.74U
* device instance $4 r0 *1 1.04,0.47 NMOS
M$4 \$20 \$3 \$1 \$1 NMOS L=0.06U W=0.54U AS=0.054P AD=0.054P PS=0.74U PD=0.74U
* device instance $5 r0 *1 1.3,0.47 NMOS
M$5 \$21 \$2 \$20 \$20 NMOS L=0.06U W=0.54U AS=0.054P AD=0.054P PS=0.74U
+ PD=0.74U
* device instance $6 r0 *1 1.56,0.47 NMOS
M$6 GND \$7 \$21 \$21 NMOS L=0.06U W=0.54U AS=0.054P AD=0.0918P PS=0.74U
+ PD=0.88U
* device instance $7 r0 *1 1.96,0.47 NMOS
M$7 \$4 \$1 GND GND NMOS L=0.06U W=2.16U AS=0.2538P AD=0.2484P PS=3.1U PD=3.62U
* device instance $11 r0 *1 0.26,1.43 PMOS
M$11 \$1 \$7 VDD VDD PMOS L=0.06U W=1.48U AS=0.1924P AD=0.1998P PS=2.74U
+ PD=2.02U
* device instance $12 r0 *1 0.52,1.43 PMOS
M$12 VDD \$2 \$1 \$1 PMOS L=0.06U W=1.48U AS=0.148P AD=0.148P PS=1.88U PD=1.88U
* device instance $13 r0 *1 0.78,1.43 PMOS
M$13 \$1 \$3 VDD VDD PMOS L=0.06U W=1.48U AS=0.148P AD=0.148P PS=1.88U PD=1.88U
* device instance $17 r0 *1 1.96,1.43 PMOS
M$17 \$4 \$1 VDD VDD PMOS L=0.06U W=2.96U AS=0.3478P AD=0.3404P PS=3.9U PD=4.62U
.ENDS AN3D4HPBWP
