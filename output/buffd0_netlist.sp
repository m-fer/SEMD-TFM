* cell BUFFD0HPBWP
* pin VDD
* pin GND
.SUBCKT BUFFD0HPBWP VDD GND
* device instance $1 r0 *1 0.26,0.42 NMOS
M$1 GND \$2 \$1 \$1 NMOS L=0.06U W=0.27U AS=0.0432P AD=0.0297P PS=0.86U PD=0.49U
* device instance $2 r0 *1 0.54,0.42 NMOS
M$2 \$3 \$1 GND GND NMOS L=0.06U W=0.27U AS=0.0297P AD=0.0432P PS=0.49U PD=0.86U
* device instance $3 r0 *1 0.26,1.495 PMOS
M$3 VDD \$2 \$1 \$1 PMOS L=0.06U W=0.37U AS=0.0592P AD=0.0407P PS=1.06U PD=0.59U
* device instance $4 r0 *1 0.54,1.495 PMOS
M$4 \$3 \$1 VDD VDD PMOS L=0.06U W=0.37U AS=0.0407P AD=0.0592P PS=0.59U PD=1.06U
.ENDS BUFFD0HPBWP
