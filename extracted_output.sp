* cell TOP
.SUBCKT TOP
* device instance $1 r0 *1 -383.58,137.719 NMOS
M$1 6 3 1 1 NMOS L=22.7368706394U W=113.489U AS=6635.333128P AD=2121.58674P
+ PS=339.849U PD=150.079U
* device instance $2 r0 *1 -315.59,137.719 NMOS
M$2 2 4 6 6 NMOS L=21.345343957U W=114.6495U AS=2121.58674P AD=6943.866188P
+ PS=150.079U PD=342.434U
* device instance $3 r0 *1 -406.829,-104.386 PMOS
M$3 1 3 5 5 PMOS L=20.8698165221U W=177.798U AS=10103.737577P AD=5911.9923335P
+ PS=466.062U PD=239.743U
* device instance $4 r0 *1 -320.368,-104.386 PMOS
M$4 5 4 1 1 PMOS L=25.6770118891U W=175.455U AS=5911.9923335P AD=11407.592793P
+ PS=239.743U PD=480.952U
.ENDS TOP
